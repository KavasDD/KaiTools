; Generated by build-danglings.py. Original SHA-256 verified.

defvar( xkDdoHelpPage "http://www.eda365.com/")

; load("xkDdoRun.il")

procedure( xkDdoRun(  )
  let(
    ( lDanglingLine
      lDanglingVia
      lIslandShape
      ps_DanglingForm
      ps_DanglingForm_file
      ps_DanglingForm_Port
      lDanglingObject
    )

    when( axlOKToProceed()
        axlMsgPut("\320\241\277\252\271\244\276\337\317\344\243\272\274\354\262\351\320\374\277\325\317\337\241\242\271\375\277\327\272\315\271\302\265\272" )

        lDanglingObject = xkDdoScan()
        lDanglingLine = car(lDanglingObject)
        lDanglingVia = cadr(lDanglingObject)
        lIslandShape = caddr(lDanglingObject)

        if( lDanglingVia || lDanglingLine || lIslandShape then
          ps_DanglingForm_file = strcat( axlTempDirectory() "./xkDangling_eb63b2eeaefd.form" )
          ps_DanglingForm_Port= outfile( ps_DanglingForm_file "w" )
          fprintf(ps_DanglingForm_Port "FILE_TYPE=FORM_DEFN VERSION=2\nFORM\nFIXED\nPORT 80 54\nHEADER \"D1\243\272\320\374\277\325\317\337\241\242\271\375\277\327\323\353\271\302\265\272\274\354\262\351\264\246\300\355\"\nTILE\nTABSET tset\nOPTIONS tabsetDispatch\nFLOC 2 1\nFSIZE 76 46\nTAB \"\320\374\277\325\317\337\" linesPage\nTEXT \"\312\375\301\277\243\272\"\nTLOC 1 1\nENDTEXT\nTEXT\nTLOC 11 1\nINFO ddoLineInfo 10\nENDTEXT\nFIELD ddoLineList\nFLOC 1 4\nLIST \"\" 0 0\nFSIZE 74 39\nOPTIONS multiselect\nENDFIELD\nENDTAB\nTAB \"\320\374\277\325\271\375\277\327\" viasPage\nTEXT \"\312\375\301\277\243\272\"\nTLOC 1 1\nENDTEXT\nTEXT\nTLOC 11 1\nINFO ddoViaInfo 10\nENDTEXT\nFIELD ddoViaList\nFLOC 1 4\nLIST \"\" 0 0\nFSIZE 74 39\nOPTIONS multiselect\nENDFIELD\nENDTAB\nTAB \"\271\302\265\272\" shapesPage\nTEXT \"\312\375\301\277\243\272\"\nTLOC 1 1\nENDTEXT\nTEXT\nTLOC 11 1\nINFO ddoShapeInfo 10\nENDTEXT\nFIELD ddoShapeList\nFLOC 1 4\nLIST \"\" 0 0\nFSIZE 74 39\nOPTIONS multiselect\nENDFIELD\nENDTAB\nENDTABSET\nFIELD ddoRefresh\nFLOC 3 49\nMENUBUTTON \"\313\242\320\302\" 12 3\nENDFIELD\nFIELD ddoDelete\nFLOC 18 49\nMENUBUTTON \"\311\276\263\375\" 12 3\nENDFIELD\nFLEXMODE edgegravity\nFLEX tset 0 0 1 1\nFLEX ddoLineList 0 0 1 1\nFLEX ddoViaList 0 0 1 1\nFLEX ddoShapeList 0 0 1 1\nFLEX ddoRefresh 0 1 0 0\nFLEX ddoDelete 0 1 0 0\nENDTILE\nENDFORM\n")
          close( ps_DanglingForm_Port )

          ps_DanglingForm = axlFormCreate( (gensym) ps_DanglingForm_file '(e outer) 'xkDdoUiAction t)
          axlFormSetField( ps_DanglingForm "ddoLineList" lDanglingLine )
          axlFormSetField( ps_DanglingForm "ddoViaList" lDanglingVia )
          axlFormSetField( ps_DanglingForm "ddoShapeList" lIslandShape )
          axlFormSetField( ps_DanglingForm "ddoLineInfo" length(lDanglingLine) )
          axlFormSetField( ps_DanglingForm "ddoViaInfo" length(lDanglingVia) )
          axlFormSetField( ps_DanglingForm "ddoShapeInfo" length(lIslandShape) )
          axlFormColorize( ps_DanglingForm "ddoLineInfo" 'text 'red )
          axlFormColorize( ps_DanglingForm "ddoViaInfo" 'text 'red )
          axlFormColorize( ps_DanglingForm "ddoShapeInfo" 'text 'red )

          xkDdoShowPage(ps_DanglingForm 'lines)
          axlFormDisplay( ps_DanglingForm )
          xkDdoActiveForm = ps_DanglingForm
          when( lDanglingLine
            axlMsgPut(sprintf(nil "\267\242\317\326 %d \314\365\320\374\277\325\317\337\243\254\307\353\262\351\277\264\320\374\277\325\317\337\322\263" length(lDanglingLine) ))
          )
          when( lDanglingVia
            axlMsgPut(sprintf(nil "\267\242\317\326 %d \270\366\320\374\277\325\271\375\277\327\243\254\307\353\262\351\277\264\320\374\277\325\271\375\277\327\322\263" length(lDanglingVia) ))
          )
          when( lIslandShape
            axlMsgPut(sprintf(nil "\267\242\317\326 %d \270\366\271\302\265\272\243\254\307\353\262\351\277\264\271\302\265\272\322\263" length(lIslandShape) ))
          )
          axlUIWPrint( ps_DanglingForm "\321\241\324\361\301\320\261\355\317\356\266\250\316\273\243\254\321\241\326\320\272\363\277\311\311\276\263\375\243\273\323\322\311\317\275\307 \241\301 \271\330\261\325\264\260\277\332\241\243" )

          deleteFile(ps_DanglingForm_file)
        else
          axlMsgPut("\316\264\267\242\317\326\320\374\277\325\317\337\241\242\271\375\277\327\273\362\271\302\265\272\241\243")
        ); end if lDanglingVia || lDanglingLine || lIslandShape
    ); end when
  ); end let
); end xkDdoRun

procedure( xkDdoFormAction( ps_DanglingForm1 @optional actionField )
  let(
    ( lDanglingVia
      lDanglingLine
      lIslandShape
      lIssueCline
      lTemp
      sLayer
      fStartX
      fStartY
      fEndX
      fEndY
      sStart
      sEnd
      lSeg
      lStartA
      lStartB
      lEndA
      lEndB
      sStartTempA
      sStartTempB
      sEndTempA
      sEndTempB
      fCoordX
      fCoordY
      dVia
      lVia
      fFindRange
      lClines
      sNet
      sMessage
      lViaInfo
      lShapeInfo
      lShape
      dShape
      lDanglingObject
      lSys
      lCoord
      bShape
      bDRC
    )
    fFindRange = axlMKSConvert(1 "MILS")
    case( or(actionField ps_DanglingForm1->curField)
      ( "ddoRefresh"
        axlClearSelSet()
        lDanglingObject = xkDdoScan()
        lDanglingLine = car(lDanglingObject)
        lDanglingVia = cadr(lDanglingObject)
        lIslandShape = caddr(lDanglingObject)

        if( lDanglingLine || lDanglingVia || lIslandShape then
          when( lDanglingLine
            axlMsgPut(sprintf(nil "\267\242\317\326 %d \314\365\320\374\277\325\317\337\243\254\307\353\262\351\277\264\320\374\277\325\317\337\322\263" length(lDanglingLine) ))
          )
          when( lDanglingVia
            axlMsgPut(sprintf(nil "\267\242\317\326 %d \270\366\320\374\277\325\271\375\277\327\243\254\307\353\262\351\277\264\320\374\277\325\271\375\277\327\322\263" length(lDanglingVia) ))
          )
          when( lIslandShape
            axlMsgPut(sprintf(nil "\267\242\317\326 %d \270\366\271\302\265\272\243\254\307\353\262\351\277\264\271\302\265\272\322\263" length(lIslandShape) ))
          )
        else
          axlMsgPut("\316\264\267\242\317\326\320\374\277\325\317\337\241\242\271\375\277\327\273\362\271\302\265\272\241\243")
        )
        axlFormListDeleteAll( ps_DanglingForm1 "ddoLineList" )
        axlFormListDeleteAll( ps_DanglingForm1 "ddoViaList" )
        axlFormListDeleteAll( ps_DanglingForm1 "ddoShapeList" )
        axlFormSetField( ps_DanglingForm1 "ddoLineList" lDanglingLine )
        axlFormSetField( ps_DanglingForm1 "ddoViaList" lDanglingVia )
        axlFormSetField( ps_DanglingForm1 "ddoShapeList" lIslandShape )
        axlFormSetField( ps_DanglingForm1 "ddoLineInfo" length(lDanglingLine) )
        axlFormSetField( ps_DanglingForm1 "ddoViaInfo" length(lDanglingVia) )
        axlFormSetField( ps_DanglingForm1 "ddoShapeInfo" length(lIslandShape) )
        axlFormColorize(ps_DanglingForm1 "ddoLineInfo" 'text 'red)
        axlFormColorize(ps_DanglingForm1 "ddoViaInfo" 'text 'red)
        axlFormColorize(ps_DanglingForm1 "ddoShapeInfo" 'text 'red)
      )
      ( "ddoLineList"
        lDanglingLine = axlFormListGetSelItems(ps_DanglingForm1 "ddoLineList")
        axlClearSelSet()
        axlSetFindFilter( ?enabled  '("noall" "clines") ?onButtons '("clines") )
        lIssueCline = nil
        axlVisibleDesign(nil)
        foreach( sline lDanglingLine
          lTemp = parseString( sline "," )
          sLayer = car( lTemp )
          lCoord = parseString(caddr(lTemp) " ()to")
          fStartX = atof(car(lCoord))
          fStartY = atof(cadr(lCoord))
          fEndX = atof(caddr(lCoord))
          fEndY = atof(nth(3 lCoord))
          axlVisibleLayer(strcat("etch/" sLayer) t)
          axlVisibleLayer(strcat("via class/" sLayer) t)
          axlVisibleLayer(strcat("pin/" sLayer) t)
          sStart = sprintf(nil "x%0.3fy%0.3f" fStartX fStartY)
          sEnd = sprintf(nil "x%0.3fy%0.3f" fEndX fEndY)
          lClines = axlGetSelSet(
                      axlSingleSelectBox(
                        list((fStartX-fFindRange):(fStartY-fFindRange)
                          (fStartX+fFindRange):(fStartY+fFindRange))
                      ))
          axlClearSelSet()
          if( lClines then
            foreach( cline lClines
              lSeg = cline->segments
              lStartA = car(car(lSeg)->startEnd)
              lEndA = cadr(car(last(lSeg))->startEnd)
              sStartTempA = sprintf( nil "x%0.3fy%0.3f" car(lStartA) cadr(lStartA))
              sEndTempA = sprintf( nil "x%0.3fy%0.3f" car(lEndA) cadr(lEndA))

              lStartB = car(car(last(lSeg))->startEnd)
              lEndB = cadr(car(lSeg)->startEnd)
              sStartTempB = sprintf( nil "x%0.3fy%0.3f" car(lStartB) cadr(lStartB))
              sEndTempB = sprintf( nil "x%0.3fy%0.3f" car(lEndB) cadr(lEndB))

              when( (sStartTempA==sStart && sEndTempA==sEnd) ||
                  (sStartTempA==sEnd && sEndTempA==sStart) ||
                  (sStartTempB==sStart && sEndTempB==sEnd) ||
                  (sStartTempB==sEnd && sEndTempB==sStart)
                lIssueCline = cons( cline lIssueCline )
              )
            )
          else
            axlUIWPrint( ps_DanglingForm1 "\316\264\325\322\265\275\266\324\323\246\327\337\317\337\243\254\307\353\312\326\266\257\266\250\316\273\241\243" )
          )
        )
        axlHighlightObject(lIssueCline)
        axlZoomToDbid(lIssueCline t)
      )
      ( "ddoViaList"

        when( lDanglingVia = axlFormListGetSelItems(ps_DanglingForm1 "ddoViaList")

          axlClearSelSet()
          axlSetFindFilter( ?enabled  '("noall" "vias") ?onButtons '("vias") )
          lVia = nil
          axlVisibleDesign(nil)
          foreach( svia lDanglingVia
            lViaInfo = parseString(svia ",")
            axlVisibleLayer(strcat("via class/" car(lViaInfo)) t)
            axlVisibleLayer(strcat("etch/" car(lViaInfo)) t)
            axlVisibleLayer(strcat("pin/" car(lViaInfo)) t)
            lCoord = parseString(caddr(lViaInfo) " ()")
            fCoordX = atof(car(lCoord))
            fCoordY = atof(cadr(lCoord))
            dVia = car(axlGetSelSet(axlSingleSelectPoint(fCoordX:fCoordY)))
            axlClearSelSet()
            when( dVia
              lVia = cons( dVia lVia)
            )
          )
          axlHighlightObject(lVia)
          axlZoomToDbid(lVia t)
        )
      )
      ( "ddoShapeList"

        when( lIslandShape = axlFormListGetSelItems(ps_DanglingForm1 "ddoShapeList")

          axlClearSelSet()
          axlSetFindFilter( ?enabled  '("noall" "shapes") ?onButtons '("shapes") )
          lShape = nil
          axlVisibleDesign(nil)
          foreach( shape lIslandShape
            lShapeInfo = parseString(shape ",")
            axlVisibleLayer(strcat("via class/" car(lShapeInfo)) t)
            axlVisibleLayer(strcat("etch/" car(lShapeInfo)) t)
            axlVisibleLayer(strcat("pin/" car(lShapeInfo)) t)
            lCoord = parseString(caddr(lShapeInfo) " ()")
            fCoordX = atof(car(lCoord))
            fCoordY = atof(cadr(lCoord))
            dShape = car(axlGetSelSet(axlSingleSelectPoint(fCoordX:fCoordY)))
            axlClearSelSet()
            when( dShape
              lShape = cons( dShape lShape )
            )
          )
          axlHighlightObject(lShape)
          axlZoomToDbid(lShape t)
        )
      )
      ( "ddoLinesDel"
        when( lDanglingLine = axlFormListGetSelItems(ps_DanglingForm1 "ddoLineList")
          axlClearSelSet()
          axlSetFindFilter( ?enabled  '("noall" "clines") ?onButtons '("clines") )
          lIssueCline = nil
          axlVisibleDesign(nil)
          foreach( sline lDanglingLine
            lTemp = parseString( sline "," )
            sLayer = car( lTemp )
            lCoord = parseString(caddr(lTemp) " ()to")
            fStartX = atof(car(lCoord))
            fStartY = atof(cadr(lCoord))
            fEndX = atof(caddr(lCoord))
            fEndY = atof(nth(3 lCoord))
            axlVisibleLayer(strcat("etch/" sLayer) t)
            axlVisibleLayer(strcat("via class/" sLayer) t)
            axlVisibleLayer(strcat("pin/" sLayer) t)
            sStart = sprintf(nil "x%0.3fy%0.3f" fStartX fStartY)
            sEnd = sprintf(nil "x%0.3fy%0.3f" fEndX fEndY)
            lClines = axlGetSelSet(
                      axlSingleSelectBox(
                        list((fStartX-fFindRange):(fStartY-fFindRange)
                          (fStartX+fFindRange):(fStartY+fFindRange))
                      ))
            axlClearSelSet()
            when( lClines
              foreach( cline lClines
                lSeg = cline->segments
                lStartA = car(car(lSeg)->startEnd)
                lEndA = cadr(car(last(lSeg))->startEnd)
                sStartTempA = sprintf( nil "x%0.3fy%0.3f" car(lStartA) cadr(lStartA))
                sEndTempA = sprintf( nil "x%0.3fy%0.3f" car(lEndA) cadr(lEndA))
                lStartB = car(car(last(lSeg))->startEnd)
                lEndB = cadr(car(lSeg)->startEnd)
                sStartTempB = sprintf( nil "x%0.3fy%0.3f" car(lStartB) cadr(lStartB))
                sEndTempB = sprintf( nil "x%0.3fy%0.3f" car(lEndB) cadr(lEndB))
                when( (sStartTempA==sStart && sEndTempA==sEnd) ||
                    (sStartTempA==sEnd && sEndTempA==sStart) ||
                    (sStartTempB==sStart && sEndTempB==sEnd) ||
                    (sStartTempB==sEnd && sEndTempB==sStart)
                  lIssueCline = cons( cline lIssueCline )
                )
              )
            ); end when lClines
          ); end foreach
          axlDeleteObject(lIssueCline)
          axlFormListDeleteItem(ps_DanglingForm1 "ddoLineList" lDanglingLine)
          axlMsgPut("\322\321\311\276\263\375\313\371\321\241\320\374\277\325\317\337\241\243")
        ); end when dline
      )
      ( "ddoViasDel"
        bDRC = axlDBControl('drcEnable nil)
        bShape = axlDBControl( 'dynamicFillMode nil )
        if( lDanglingVia = axlFormListGetSelItems(ps_DanglingForm1 "ddoViaList")  then
          axlClearSelSet()
          axlSetFindFilter( ?enabled  '("noall" "vias") ?onButtons '("vias") )
          lVia = nil
          lSys = axlVisibleGet()
          axlVisibleDesign(nil)
          foreach( svia lDanglingVia
            lViaInfo = parseString(svia ",")
            axlVisibleLayer(strcat("via class/" car(lViaInfo)) t)
            lCoord = parseString(caddr(lViaInfo) " ()")
            fCoordX = atof(car(lCoord))
            fCoordY = atof(cadr(lCoord))
            dVia = car(axlGetSelSet(axlSingleSelectPoint(fCoordX:fCoordY)))
            axlClearSelSet()
            when( dVia
              lVia = cons( dVia lVia)
            )
            axlVisibleLayer(strcat("via class/" car(lViaInfo)) nil)
          )
          axlDeleteObject(lVia)
          axlFormListDeleteItem(ps_DanglingForm1 "ddoViaList" lDanglingVia)
          axlMsgPut("\322\321\311\276\263\375\313\371\321\241\320\374\277\325\271\375\277\327\241\243")
          axlVisibleSet(lSys)
        else
          axlUIConfirm("\307\353\317\310\324\332\301\320\261\355\326\320\321\241\324\361\322\252\311\276\263\375\265\304\266\324\317\363\241\243")
        )
        axlDBControl('drcEnable bDRC)
        axlDBControl( 'dynamicFillMode bShape )
      )
      ( "ddoShapesDel"
        axlMsgPut("\310\364\271\302\265\272\311\276\263\375\275\317\302\375\243\254\277\311\312\271\323\303\320\316\327\264\262\313\265\245\265\304\311\276\263\375\271\302\265\272\271\246\304\334\243\254\324\331\313\242\320\302\270\264\262\351\241\243")
        bDRC = axlDBControl('drcEnable nil)
        bShape = axlDBControl( 'dynamicFillMode nil )
        if( lIslandShape = axlFormListGetSelItems(ps_DanglingForm1 "ddoShapeList")  then
          axlClearSelSet()
          axlSetFindFilter( ?enabled  '("noall" "shapes") ?onButtons '("shapes") )
          lShape = nil
          lSys = axlVisibleGet()
          axlVisibleDesign(nil)
          foreach( shape lIslandShape
            lShapeInfo = parseString(shape ",")
            axlVisibleLayer(strcat("via class/" car(lShapeInfo)) t)
            axlVisibleLayer(strcat("etch/" car(lShapeInfo)) t)
            axlVisibleLayer(strcat("pin/" car(lShapeInfo)) t)
            lCoord = parseString(caddr(lShapeInfo) " ()")
            fCoordX = atof(car(lCoord))
            fCoordY = atof(cadr(lCoord))
            dShape = car(axlGetSelSet(axlSingleSelectPoint(fCoordX:fCoordY)))
            axlClearSelSet()
            when( dShape
              if( dShape->shapeBoundary then
                ;  need to use current dynamic shape and void this island shape
                dVoidPoly=car(axlPolyFromDB(dShape))   ; to be void poly
                dDynaShapePoly=car(axlPolyFromDB(dShape->shapeBoundary))  ; dynamic shape poly
                dNewPoly  = car(axlPolyOperation(dDynaShapePoly dVoidPoly 'ANDNOT))  ; new shape poly
                sNet = dShape->net->name
                sLayer = dShape->shapeBoundary->layer
                lDynShapeGroup = car(dShape->parentGroups)
                axlDeleteObject(dShape->shapeBoundary)  ; delete original shape
                dNewShape = car(axlDBCreateShape(dNewPoly t sLayer sNet))  ; create new shape
                dParent=car(car(dNewShape->shapeAuto)->parentGroups)
                axlShapeDynamicUpdate(dNewShape, t) ;update the shape, this is a time causing step
              else
                lShape = cons( dShape lShape )
              )
            )
            axlVisibleLayer(strcat("etch/" car(lShapeInfo)) nil)
          )
          axlDeleteObject(lShape) ; delete static/whole dynamic shape
          axlFormListDeleteItem(ps_DanglingForm1 "ddoShapeList" lIslandShape)
          axlMsgPut("\322\321\311\276\263\375\313\371\321\241\271\302\265\272\241\243")
          axlVisibleSet(lSys)
          axlFlushDisplay()
        else
          axlUIConfirm("\307\353\317\310\324\332\301\320\261\355\326\320\321\241\324\361\322\252\311\276\263\375\265\304\266\324\317\363\241\243")
        )
        axlDBControl('drcEnable bDRC)
        axlDBControl( 'dynamicFillMode bShape )
      )
      ( "ddoClose"
        axlFormClose( ps_DanglingForm1 )
        axlClearSelSet()
        axlFlushDisplay()
        axlEndSkillMode()
        axlMsgPut("\264\246\300\355\315\352\263\311\243\254\307\353\270\374\320\302 DRC \262\242\313\242\320\302\315\255\306\244\241\243")
      )
      ( "ddoAssign"
        bDRC = axlDBControl('drcEnable nil)
        bShape = axlDBControl( 'dynamicFillMode nil )
        if( lDanglingVia = axlFormListGetSelItems(ps_DanglingForm1 "ddoViaList")  then
          axlClearSelSet()
          axlSetFindFilter( ?enabled  '("noall" "vias") ?onButtons '("vias") )
          lVia = nil
          lSys = axlVisibleGet()
          axlVisibleDesign(nil)
          foreach( svia lDanglingVia
            lViaInfo = parseString(svia ",")
            axlVisibleLayer(strcat("via class/" car(lViaInfo)) t)
            lCoord = parseString(caddr(lViaInfo) " ()")
            fCoordX = atof(car(lCoord))
            fCoordY = atof(cadr(lCoord))
            dVia = car(axlGetSelSet(axlSingleSelectPoint(fCoordX:fCoordY)))
            axlClearSelSet()
            when( dVia
              lVia = cons( dVia lVia)
            )
            axlVisibleLayer(strcat("via class/" car(lViaInfo)) nil)
          )
          axlMsgPut("\307\353\324\332\260\345\315\274\326\320\265\343\273\367\321\241\324\361\304\277\261\352\315\370\302\347\241\243")
          axlVisibleSet(lSys)

          axlSetFindFilter( ?enabled  '("noall" "nets") ?onButtons '("nets") )
          if( axlSingleSelectPoint() then
            sNet = car(axlGetSelSet())->name
            axlClearSelSet()
            foreach( item lVia
              axlDBCloak( 'axlDBCreateVia( item->name item->xy sNet ) 'shape )
              if( item->net->name then
                  sMessage = sprintf( nil "\271\375\277\327\315\370\302\347\322\321\264\323 %s \270\304\316\252 %s" item->net->name sNet )
              else
                  sMessage = sprintf( nil "\316\336\315\370\302\347\271\375\277\327\322\321\270\304\316\252 %s" sNet )
              ); end if
              axlMsgPut( sMessage )
            )
            axlDeleteObject(lVia)
            axlFormListDeleteItem(ps_DanglingForm1 "ddoViaList" lDanglingVia)
            ;axlMsgPut("\322\321\320\336\270\304\271\375\277\327\315\370\302\347\241\243")
          else
            axlMsgPut("\316\264\321\241\265\275\323\320\320\247\315\370\302\347\243\254\303\273\323\320\320\336\270\304\241\243")
          ); end when
        else
          axlUIConfirm("\307\353\317\310\324\332\301\320\261\355\326\320\321\241\324\361\322\252\320\336\270\304\315\370\302\347\265\304\271\375\277\327\241\243")
        )
        axlDBControl('drcEnable bDRC)
        axlDBControl( 'dynamicFillMode bShape )
      )
      ( "ddoHelp"
        axlHttp( xkDdoHelpPage )
      )
    )
  )
)

procedure( xkDdoScan()
  let(
    ( lClines
      lVias
      sNet
      sVia
      lDanglingLine
      bIgnore
      lDanglingVia
      lIslandShape
      sShape
      sLine
    )
    axlClearSelSet()
    axlSetFindFilter( ?enabled  '("noall" "invisible" "clines" ) ?onButtons '("clines" ) )
    lClines = axlGetSelSet(axlAddSelectAll())
    axlClearSelSet()
    axlSetFindFilter( ?enabled  '("noall" "invisible"  "vias") ?onButtons '( "vias") )
    lVias = axlGetSelSet(axlAddSelectAll())
    axlClearSelSet()
    foreach( cline lClines
      when( length(axlDBGetConnect( cline t ))<2
        unless(cline->prop->FILLET||cline->symbolEtch
          if(cline->net then
            sNet = cline->net->name
          else
            sNet = "Dummy"
          )
          sLine = sprintf(nil "%s, %s, %L to %L"
            cadr(parseString(cline->layer "/"))
            sNet
            car(car(cline->segments)->startEnd)
            cadr(car(last(cline->segments))->startEnd)
          )
          lDanglingLine = cons( sLine lDanglingLine )
        )
      )
    )

    lDanglingLine = reverse(sort(lDanglingLine nil))
    foreach( via lVias
      unless( via->symbolEtch ;;; ignore symbol type via
        bIgnore = nil
        if(via->net then
          sNet = via->net->name
          when( rexMatchp("^SNN_" sNet)
            bIgnore = t
          )
        else
          sNet = "Dummy"
        )
        sVia = sprintf( nil "%s, %s, %L"
          cadr(parseString(car(via->startEnd) "/"))
          sNet
          via->xy
        )
        unless( bIgnore
          when( onep(length(axlDBGetConnect( via t )))
            unless( via->testPoint || rexMatchp("_VOID$" via->name )
              lDanglingVia = cons( sVia lDanglingVia )
            )
          )
          when( zerop(length(axlDBGetConnect( via t )))
             lDanglingVia = cons( sVia lDanglingVia )
          ); end when
        ); end unless bIgnore
      ); end unless
    )
    lDanglingVia = reverse(sort(lDanglingVia nil))
    foreach( shape axlDBGetShapes("etch")
      when( length(axlDBGetConnect(shape t))<2
        unless( shape->symbolEtch
          sNet = "Dummy"
          when( shape->net && shape->net->name != ""
            sNet = shape->net->name
          )
          sShape = sprintf(nil "%s, %s, %L"
              cadr(parseString(shape->layer "/"))
              sNet
              car(car(shape->segments)->startEnd)
            )
          lIslandShape = cons( sShape lIslandShape )
        ); end unless
      ); end when
    )
    foreach(net axlDBGetDesign()->nets
      when( net->nBranches > 1
        foreach( branch cdr(net->branches)
          foreach( obj branch->children
            when( obj->objType == "shape"
              sShape = sprintf(nil "%s, %s, %L"
                  cadr(parseString(obj->layer "/"))
                  net->name
                  car(car(obj->segments)->startEnd)
                )
              unless( member( sShape lIslandShape )
                lIslandShape = cons( sShape lIslandShape )
              )
            )
          ); end obj
        ); end branch
      ); end when
    ); end foreach

    lIslandShape = reverse(sort(lIslandShape nil))
    list(lDanglingLine lDanglingVia lIslandShape)
  ); end let
); end xkDdoScan
procedure(xkDdoShowPage(form page)
  form->XkPage = page
)
procedure(xkDdoUiAction(form)
  let((field)
    field = form->curField
    cond(
      (field == "tset"
        cond(
          (member(form->curValue '("linesPage" "\320\374\277\325\317\337")) xkDdoShowPage(form 'lines))
          (member(form->curValue '("viasPage" "\320\374\277\325\271\375\277\327")) xkDdoShowPage(form 'vias))
          (member(form->curValue '("shapesPage" "\271\302\265\272")) xkDdoShowPage(form 'shapes))
        )
      )
      (field == "ddoDelete"
        xkDdoFormAction(form case(form->XkPage
          (lines "ddoLinesDel") (vias "ddoViasDel") (shapes "ddoShapesDel")))
      )
      (member(field '("done" "cancel")) xkDdoFormAction(form "ddoClose"))
      (t xkDdoFormAction(form))
    )
  )
)
procedure(xkDdoCheckEntry() xkDdoRun())
axlCmdRegister("xk_dangling_check" 'xkDdoCheckEntry ?cmdType "general")
axlCmdRegister("xk_dangling_vias" 'x_change_via_net)
axlCmdRegister("xk_via_change_net" 'x_change_via_net)
