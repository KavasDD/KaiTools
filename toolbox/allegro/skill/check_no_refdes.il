axlCmdRegister( "Check_No_Refdes" 'Check_No_Refdes)

defun( Check_No_Refdes ()

        axlVisibleDesign(nil)
 	axlVisibleLayer( "BOARD GEOMETRY/OUTLINE" t )
	axlVisibleLayer( "PIN/TOP" t )
axlVisibleLayer("PACKAGE GEOMETRY/ASSEMBLY_TOP" t)
axlVisibleLayer("PACKAGE GEOMETRY/ASSEMBLY_BOTTOM" t)
axlVisibleLayer("PACKAGE GEOMETRY/PLACE_BOUND_TOP" t)
axlVisibleLayer("PACKAGE GEOMETRY/PLACE_BOUND_BOTTOM" t)
	axlVisibleLayer( "PIN/BOTTOM" t )
	axlVisibleLayer( "REF DES/SILKSCREEN_TOP" t )
	axlVisibleLayer( "REF DES/SILKSCREEN_BOTTOM" t )
	axlVisibleLayer( "PACKAGE GEOMETRY/SILKSCREEN_TOP" t )
	axlVisibleLayer( "PACKAGE GEOMETRY/SILKSCREEN_BOTTOM" t )

	logfile = axlDMOpenLog("no_refdes.log")
	fprintf(logfile "#Check the component without refdes . \n\n")
	fprintf(logfile "REF_DES  COORDIRATION\n")

	setq(allsym axlDBGetDesign()->symbols)
	axlDehighlightObject(allsym)
	noref = nil
	norefcnt = 0
	foreach(symbol allsym
		text= axlDBGetAttachedText(symbol)
		txt = nil
		foreach(find text
			if(find->layer == "REF DES/SILKSCREEN_TOP" ||
			find->layer == "REF DES/SILKSCREEN_BOTTOM" then
				txt = find
			)
		)
		if(txt == nil && symbol->refdes != nil then
			axlHighlightObject(symbol)
			fprintf(logfile "%-8s %L\n" symbol->refdes symbol->xy)
			;noref = cons(symbol->refdes noref)
			++norefcnt
		)
	);foreach-end

	fprintf(logfile "\nTotal of no refdes: %d\n" norefcnt)
	axlDMClose(logfile)
 axlVisibleUpdate(t)
 axlZoomFit(nil 'visible)
 axlUIWRedraw(nil)
 axlUIWExpose(axlUIViewFileCreate("no_refdes.log" "\104\067\040\310\261\312\247\313\277\323\241\316\273\272\305\274\354\262\351\261\250\270\346" nil))

	axlMsgPut("Total component without refdes: %d\n" norefcnt)
	axlMsgPut("Components without refdes , please view logfile.")
);defun_end
