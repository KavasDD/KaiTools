; Minimal database doubles in the real SKILL interpreter. No board files.
procedure(axlCmdRegister(@rest args) t)
procedure(axlTriggerClear(@rest args) t)
procedure(axlTriggerSet(@rest args) t)
procedure(axlUIMenuFind(@rest args) nil)
procedure(axlMsgPut(@rest args) t)
procedure(xkTestWriteProcess(process data) xkTestMessages = cons(data xkTestMessages) t)
procedure(axlDBGetDesign() xkTestDesign)
procedure(axlShellPost(command) xkTestCommand = command t)
procedure(axlTempFile() "D:/selfsoftware/out/ai-skill-test-context.txt")
procedure(xkTestAssert(value message) unless(value error("FAIL: %s" message)))
load("D:/selfsoftware/out/ai-skill-test-adapter.il")
procedure(xkLocateComponent(index) xkTestIndex = index t)
defstruct(xkTestBoard name components)
defstruct(xkTestComponent name symbol)
xkTestDesign = make_xkTestBoard(?name "fixture.brd" ?components list(
  make_xkTestComponent(?name "R1" ?symbol t) make_xkTestComponent(?name "U1" ?symbol t)))
xkToolboxHotkeyProcess = 1
xkTestMessages = nil
xkAiContext("first")
xkTestAssert(xkAiRequest == "first" "context request")
xkTestAssert(xkAiNames == '("R1" "U1") "component context")
xkTestAssert(rexMatchp("^AI_CONTEXT_FILE first " car(xkTestMessages)) "context response")
xkAiAction(list("AI_ACTION" "first" "locate" "1"))
xkTestAssert(xkTestIndex == 1 "locate mapped component")
xkTestAssert(car(xkTestMessages) == "AI_RESULT first OK\n" "locate acknowledgement")
xkAiAction(list("AI_ACTION" "first" "locate" "0"))
xkTestAssert(xkTestIndex == 1 "consumed request cannot replay")
xkAiContext("switch")
xkTestDesign = make_xkTestBoard(?name "other.brd" ?components nil)
xkAiAction(list("AI_ACTION" "switch" "open_tool" "grid"))
xkTestAssert(car(xkTestMessages) == "AI_RESULT switch FAILED\n" "board switch rejected")
xkAiContext("tool")
xkAiAction(list("AI_ACTION" "tool" "open_tool" "grid"))
xkTestAssert(xkTestCommand == "quick_grids" "tool mapping")
xkAiContext("unknown")
xkAiAction(list("AI_ACTION" "unknown" "open_tool" "exit"))
xkTestAssert(car(xkTestMessages) == "AI_RESULT unknown FAILED\n" "unsupported tool rejected")
xkTestAssert(xkTestCommand == "quick_grids" "unsupported tool did not execute")
xkAiContext("cancel")
xkToolboxHandleLine("AI_CANCEL cancel")
xkAiAction(list("AI_ACTION" "cancel" "open_tool" "drc"))
xkTestAssert(car(xkTestMessages) == "AI_RESULT cancel FAILED\n" "cancelled request rejected")
deleteFile(xkAiDataFile)
printf("PASS: generated Allegro SKILL, context, locate, tool mapping, stale/replay/cancel/unknown rejection\n")
exit(0)
